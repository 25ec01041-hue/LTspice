* D:\EDA_LTSPICE\Q1.asc
* Generated by LTspice 26.0.2 for Windows.

.lib C:\Users\kushw\AppData\Local\LTspice\lib\cmp\standard.mos
.OPTIONS ALLOW_AMBIGUOUS_MODELS
.include 65nm_bulk_organized.pm
M1 d g 0 0 nmos L=70n W=1u ; drain gate source body model size
Vd d 0 1.1
Vg g 0 1.1

.op
.backanno
.end
